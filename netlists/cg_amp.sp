* Common-gate amplifier
vDD vdd 0 dc=1.8 ac=0
vG gate 0 dc=0.8 ac=0
VIn in 0 dc=0 ac=1
rD vdd out 1.0e4
mn1 out gate in 0 nmos
