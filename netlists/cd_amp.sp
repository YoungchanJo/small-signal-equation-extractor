* Common-drain amplifier
vDD vdd 0 dc=1.8 ac=0
VIn in 0 dc=0.8 ac=1
rL out 0 1.0e4
mn1 vdd in out 0 nmos
